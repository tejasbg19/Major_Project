ADE simulation setup
Test PLL_VCO_sch1_1: PLL/VCO_sch1/schematic, simulator spectre
  Models: /home/install/FOUNDRY/analog/45nm/gpdk045/../models/spectre/gpdk045.scs[mc]
  Variables: Vin = 0.1
  Temperature: 27
  Initial conditions: /net3 = 0
  Analysis tran: stop=1u errpreset=moderate
  Output frequency(VT("/Vout"))
  Signals: /Vout
