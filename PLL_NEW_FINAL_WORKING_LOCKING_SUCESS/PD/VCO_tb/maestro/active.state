ADE simulation setup
Test PD_VCO_tb_1: PD/VCO_tb/schematic, simulator spectre
  Models: /home/install/FOUNDRY/analog/45nm/gpdk045/../models/spectre/gpdk045.scs[mc]
  Variables: vin = 450m
  Temperature: 27
  Initial conditions: /vout = 0
  Node sets: /vout = 0
  Analysis pstb: start=1m stop=10G fund=4.80G probe=/I0/IPRB0
  Analysis tran: stop=200n errpreset=moderate
  Analysis pnoise: start=1m stop=2G fund=4.80G p=/vout n=/gnd! sweeptype=relative relharmnum=1 noisetype=timeaverage
  Analysis pss: engine=Shooting fund=4.80G harms=30 tstab=1u oscana=t p=/vout n=/gnd! errpreset=moderate
  Output Freq_Vout = frequency(VT("/vout"))
  Output Power = average(getData(":pwr" ?result "tran"))
  Output output noise: (PM, DSB, dBc/Hz) = rfOutputNoise("dBc/Hz" ?result "pnoise_pm" ?noiseConvention "DSB") (unticked)
  Output output noise @ 1M;(PM, DSB, dBc/Hz) = drplRFValueAt(rfOutputNoise("dBc/Hz" ?result "pnoise_pm" ?noiseConvention "DSB") "1M") (unticked)
  Output RMS Jitter = drplRFJc(?from 0.0010004 ?to 2000000000 ?k 100 ?multiplier 1 ?result "pnoise_pm" ?unit "Second") (unticked)
  Output Cycle to Cycle Jitter = drplRFJcc(?from 0.0010004 ?to 2000000000 ?k 100 ?multiplier 1 ?result "pnoise_pm" ?unit "Second") (unticked)
  Signals: /vout as Vout
Run mode: Single Run, Sweeps and Corners
Setup values for test PD_VCO_tb_1: vin = {From/To}Auto:0:12:1.1{From/To}
