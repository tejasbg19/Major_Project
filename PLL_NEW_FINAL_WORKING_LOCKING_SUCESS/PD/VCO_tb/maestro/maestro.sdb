ADE simulation setup
Run mode: Single Run, Sweeps and Corners
Tests:
  PD_VCO_tb_1: PD/VCO_tb/schematic, simulator spectre
    Variables: vin = {From/To}Auto:0:12:1.1{From/To}
