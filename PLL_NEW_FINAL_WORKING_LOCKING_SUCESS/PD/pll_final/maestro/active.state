ADE simulation setup
Test PD_pll_final_1: PD/pll_final/schematic, simulator spectre
  Models: /home/install/FOUNDRY/analog/45nm/gpdk045/../models/spectre/gpdk045.scs[mc]
  Temperature: 27
  Initial conditions: /I1/net1 = 0
  Node sets: /I1/net1 = 0
  Analysis pstb: start=1m stop=10G fund=101.9160212M probe=/I1/IPRB0
  Analysis tran: stop=3u errpreset=moderate
  Analysis pnoise: start=1m stop=2G fund=101.9160212M p=/Vout n=/gnd! sweeptype=relative relharmnum=1 noisetype=timeaverage
  Analysis pss: engine=Shooting fund=101.9160212M harms=30 tstab=3u errpreset=moderate
  Output frequency(VT("/Vout"))
  Output frequency(VT("/Vf"))
  Signals: /Vout as PLL_output, /Vf as Feed_Back, /Vref as Reference Input, /Down, /Up, /Vc as VCO_cntrl_Voltage
Run mode: Single Run, Sweeps and Corners
