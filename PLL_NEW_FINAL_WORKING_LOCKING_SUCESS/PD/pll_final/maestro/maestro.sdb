ADE simulation setup
Run mode: Single Run, Sweeps and Corners
Tests:
  PD_pll_final_1: PD/pll_final/schematic, simulator spectre
