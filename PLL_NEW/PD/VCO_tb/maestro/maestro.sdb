ADE simulation setup
Run mode: Single Run, Sweeps and Corners
Tests:
  PD_VCO_tb_1: PD/VCO_tb/config, simulator spectre
    Variables: vin = {From/To}Auto:0:15:1.4{From/To}
