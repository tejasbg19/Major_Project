ADE simulation setup
Test PD_VCO_tb_1: PD/VCO_tb/config, simulator spectre
  Models: /home/install/FOUNDRY/analog/45nm/gpdk045/../models/spectre/gpdk045.scs[mc]
  Variables: vin = 450m
  Temperature: 27
  Initial conditions: /vout = 0
  Node sets: /vout = 0
  Analysis tran: stop=200n errpreset=moderate
  Output Freq_Vout = frequency(VT("/vout"))
  Output Power = average(getData(":pwr" ?result "tran"))
  Output output noise: (PM, DSB, dBc/Hz) = rfOutputNoise("dBc/Hz" ?result "pnoise_pm" ?noiseConvention "DSB") (unticked)
  Output output noise @ 1M;(PM, DSB, dBc/Hz) = drplRFValueAt(rfOutputNoise("dBc/Hz" ?result "pnoise_pm" ?noiseConvention "DSB") "1M") (unticked)
  Output RMS Jitter = drplRFJc(?from 0.0010004 ?to 2000000000 ?k 100 ?multiplier 1 ?result "pnoise_pm" ?unit "Second") (unticked)
  Output Cycle to Cycle Jitter = drplRFJcc(?from 0.0010004 ?to 2000000000 ?k 100 ?multiplier 1 ?result "pnoise_pm" ?unit "Second") (unticked)
  Signals: /vout as Vout
Run mode: Single Run, Sweeps and Corners
Setup values for test PD_VCO_tb_1: vin = {From/To}Auto:0:15:1.4{From/To}
