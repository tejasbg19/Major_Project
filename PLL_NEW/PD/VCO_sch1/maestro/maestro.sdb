ADE simulation setup
Run mode: Single Run, Sweeps and Corners
Tests:
  PLL_VCO_sch1_1: PLL/VCO_sch1/schematic, simulator spectre
    Variables: Vin = {From/To}Auto:0.1:10:1.1{From/To}
